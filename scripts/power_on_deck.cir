* automatic plant watering controller - power-on test (values from CircuitIR #73)
.model NML_NMOS NMOS(VTO=2.0 KP=8.0 L=100u W=200m RD=0.15 RS=0.05)
.model DFLY    D(IS=200u N=1.6 RS=0.04 BV=40)
.model DLED    D(IS=1e-12 N=3.4 RS=5)
* LM393 open-collector: OUT pulls low (2R) when IN- > IN+, else floats (pulled up by R4)
.subckt LM393 INP INN OUT VCC VGND
BDRV NCTL VGND V = (V(INN,INP) > 1m) ? 1 : 0
S1  OUT  VGND NCTL VGND SWOC
.model SWOC SW(VT=0.5 VH=0.05 RON=2 ROFF=100MEG)
.ends

V1  VCC 0    DC 12
RS  SENSE 0  500k
R1  VCC SENSE 10k
C1  SENSE 0  100n
R2  VCC THRESH 47k
R3  THRESH 0  47k
XU1 SENSE THRESH CTRL VCC 0 LM393
R4  VCC CTRL 10k
R5  CTRL GATE 220
R6  GATE 0   100k
M1  PUMP_NEG GATE 0 0 NML_NMOS
RM1 VCC PUMP_NEG 20
D1  PUMP_NEG VCC DFLY
R7  CTRL LED_A 1k
D2  LED_A 0 DLED

.control
set noaskquit
op
wrdata power_on_result.dat v(sense) v(thresh) v(ctrl) v(gate) v(pump_neg) @rm1[i] @r7[i]
.endc
.end
